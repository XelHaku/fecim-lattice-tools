* FeCIM Array SPICE Netlist
* Generated by Module 6: FeCIM Design Suite
* Operation Mode: Compute
* Array: 64 cells

.param VDD = 1.80
VDD vdd 0 DC {VDD}

* Word Line Drivers
VWL0 wl0 0 DC 0
VWL1 wl1 0 DC 0
VWL2 wl2 0 DC 0
VWL3 wl3 0 DC 0
VWL4 wl4 0 DC 0
VWL5 wl5 0 DC 0
VWL6 wl6 0 DC 0
VWL7 wl7 0 DC 0

* Bit Line Loads (1k for sensing)
RBL0 bl0 0 1k
RBL1 bl1 0 1k
RBL2 bl2 0 1k
RBL3 bl3 0 1k
RBL4 bl4 0 1k
RBL5 bl5 0 1k
RBL6 bl6 0 1k
RBL7 bl7 0 1k

* FeFET Cells (resistor model: R = 1/G)
R_0_0 wl0 bl0 17978.92
R_0_1 wl0 bl1 25939.18
R_0_2 wl0 bl2 15183.25
R_0_3 wl0 bl3 35322.78
R_0_4 wl0 bl4 12575.89
R_0_5 wl0 bl5 55343.51
R_0_6 wl0 bl6 11140.99
R_0_7 wl0 bl7 127753.30
R_1_0 wl1 bl0 22036.47
R_1_1 wl1 bl1 16013.25
R_1_2 wl1 bl2 28459.27
R_1_3 wl1 bl3 13757.12
R_1_4 wl1 bl4 46548.96
R_1_5 wl1 bl5 12058.21
R_1_6 wl1 bl6 88957.06
R_1_7 wl1 bl7 10732.79
R_2_0 wl2 bl0 16939.25
R_2_1 wl2 bl1 28459.27
R_2_2 wl2 bl2 14435.04
R_2_3 wl2 bl3 40166.20
R_2_4 wl2 bl4 12575.89
R_2_5 wl2 bl5 68235.29
R_2_6 wl2 bl6 10732.79
R_2_7 wl2 bl7 226562.50
R_3_0 wl3 bl0 23829.09
R_3_1 wl3 bl1 15183.25
R_3_2 wl3 bl2 31521.74
R_3_3 wl3 bl3 13140.01
R_3_4 wl3 bl4 46548.96
R_3_5 wl3 bl5 11581.47
R_3_6 wl3 bl6 127753.30
R_3_7 wl3 bl7 10353.45
R_4_0 wl4 bl0 19154.56
R_4_1 wl4 bl1 23829.09
R_4_2 wl4 bl2 15183.25
R_4_3 wl4 bl3 31521.74
R_4_4 wl4 bl4 13140.01
R_4_5 wl4 bl5 46548.96
R_4_6 wl4 bl6 11581.47
R_4_7 wl4 bl7 127753.30
R_5_0 wl5 bl0 20494.70
R_5_1 wl5 bl1 16939.25
R_5_2 wl5 bl2 28459.27
R_5_3 wl5 bl3 14435.04
R_5_4 wl5 bl4 40166.20
R_5_5 wl5 bl5 12575.89
R_5_6 wl5 bl6 68235.29
R_5_7 wl5 bl7 10732.79
R_6_0 wl6 bl0 16013.25
R_6_1 wl6 bl1 28459.27
R_6_2 wl6 bl2 13757.12
R_6_3 wl6 bl3 46548.96
R_6_4 wl6 bl4 12058.21
R_6_5 wl6 bl5 88957.06
R_6_6 wl6 bl6 10732.79
R_6_7 wl6 bl7 1000000.00
R_7_0 wl7 bl0 25939.18
R_7_1 wl7 bl1 15183.25
R_7_2 wl7 bl2 35322.78
R_7_3 wl7 bl3 12575.89
R_7_4 wl7 bl4 55343.51
R_7_5 wl7 bl5 11140.99
R_7_6 wl7 bl6 127753.30
R_7_7 wl7 bl7 10000.00

* Analysis
.op
.control
run
print i(RBL0)
print i(RBL1)
print i(RBL2)
print i(RBL3)
print i(RBL4)
print i(RBL5)
print i(RBL6)
print i(RBL7)
.endc
.end
